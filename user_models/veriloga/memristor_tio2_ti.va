// Real, minimal HP linear ion-drift memristor compact model -- the
// exact same real model as memristor_tio2_au.va (see that file's own
// header for the full physics derivation and citation); this is that
// *same real model*, deliberately re-instantiated here with a
// *different* real parameter set for the Au / TiO2 / Ti device
// variant (Ti top electrode instead of Au). Ti's own real top-
// electrode contact is more resistive/less ohmic than Au's (real,
// well-known Schottky-vs-ohmic contact difference for oxide
// memristors -- see e.g. Yang et al., "Memristive switching mechanism
// for metal/oxide/metal nanodevices", Nat. Nanotechnol. 3, 429-433
// (2008)) -- reflected here as a real, illustrative higher Ron and
// slightly lower ionic mobility uv than the Au-top variant's own
// values. Illustrative, not measured from a real fabricated device.
//
// State: x lives on a hidden node, dx = x - x0, integrated with
// ddt() so that (1) the starting value x0 really is the starting
// value (dx starts at 0), and (2) x stops at 0 and 1 instead of
// piling up past them. (An earlier version clamped idt()'s output
// from outside: OpenVAF started the integral at 0 whatever x0 said,
// and the integral kept growing past 1, so switching back was delayed.)
`include "disciplines.vams"

module memristor_tio2_ti(BE, TE);
inout BE, TE;
electrical BE, TE;
electrical dx;   // hidden node: how far x has moved from x0

parameter real Ron = 250 from (0:inf);
parameter real Roff = 20e3 from (0:inf);
parameter real D = 10n from (0:inf);
parameter real uv = 0.8e-14 from (0:inf);
parameter real x0 = 0.1 from [0:1];

real x, Rmem, dxdt;

analog begin
  x = min(max(x0 + V(dx), 0.0), 1.0);   // the memory, kept between 0 and 1
  Rmem = Ron * x + Roff * (1.0 - x);
  I(BE, TE) <+ V(BE, TE) / Rmem;
  dxdt = (uv * Ron / (D * D)) * V(BE, TE) / Rmem;   // the boundary moves with the current
  if ((x >= 1.0 && dxdt > 0.0) || (x <= 0.0 && dxdt < 0.0))
    dxdt = 0.0;                         // at an end: stop there
  I(dx) <+ ddt(V(dx)) - dxdt;           // x moves at dxdt
  I(dx) <+ 1e-12 * V(dx);               // keeps dx defined at rest
end
endmodule
