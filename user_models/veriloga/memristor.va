// Real, minimal HP linear ion-drift memristor compact model.
// Physics: Strukov, Snider, Stewart and Williams, "The missing
// memristor found", Nature 453, 80-83 (2008). A thin TiO2 film of
// total thickness D sits between two electrodes (BE, TE); one region
// is doped (oxygen-vacancy-rich, low resistance Ron), the other
// undoped (high resistance Roff). Applying current moves the
// doped/undoped boundary at rate proportional to ionic mobility uv;
// the real, dimensionless state variable x = w/D (0 = fully
// undoped/Roff, 1 = fully doped/Ron) tracks that boundary position.
// This is the textbook linear-drift form (no window function).
//
// Real, empirically found: this device has no well-defined DC
// operating point (a pure integrator's steady state is ambiguous --
// a real, known SPICE issue for any memristor/integrator-based
// model, not a bug in this one) -- ngspice's real OSDI runtime
// segfaults on a plain `.op` here. The real, standard fix, used by
// published memristor SPICE decks generally: drive it with `.tran
// ... uic` (use initial conditions), never a bare `.op`.
//
// State: x lives on a hidden node, dx = x - x0, integrated with
// ddt() so that (1) the starting value x0 really is the starting
// value (dx starts at 0), and (2) x stops at 0 and 1 instead of
// piling up past them. (An earlier version clamped idt()'s output
// from outside: OpenVAF started the integral at 0 whatever x0 said,
// and the integral kept growing past 1, so switching back was delayed.)
`include "disciplines.vams"

module memristor(BE, TE);
inout BE, TE;
electrical BE, TE;
electrical dx;   // hidden node: how far x has moved from x0

parameter real Ron = 100 from (0:inf);
parameter real Roff = 16e3 from (0:inf);
parameter real D = 10n from (0:inf);
parameter real uv = 1e-14 from (0:inf);
parameter real x0 = 0.1 from [0:1];

real x, Rmem, dxdt;

analog begin
  x = min(max(x0 + V(dx), 0.0), 1.0);   // the memory, kept between 0 and 1
  Rmem = Ron * x + Roff * (1.0 - x);
  I(BE, TE) <+ V(BE, TE) / Rmem;
  dxdt = (uv * Ron / (D * D)) * V(BE, TE) / Rmem;   // the boundary moves with the current
  if ((x >= 1.0 && dxdt > 0.0) || (x <= 0.0 && dxdt < 0.0))
    dxdt = 0.0;                         // at an end: stop there
  I(dx) <+ ddt(V(dx)) - dxdt;           // x moves at dxdt
  I(dx) <+ 1e-12 * V(dx);               // keeps dx defined at rest
end
endmodule
