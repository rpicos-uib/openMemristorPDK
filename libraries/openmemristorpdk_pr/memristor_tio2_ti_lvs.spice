* NGSPICE file created from memristor_tio2_ti.ext - technology: openmemristorpdk

.subckt memristor_tio2_ti BE TE
X0 BE TE memristor_tio2_ti_prim
.ends
