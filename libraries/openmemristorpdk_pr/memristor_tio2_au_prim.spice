* Real primitive-device wrapper for the Au/TiO2/Au memristor -- the
* real name a real Magic `device subcircuit` recognition rule
* (openmemristorpdk.tech's own extract section) emits for any real
* be_au/mem_tio2/te_au stack it finds during extraction. Deliberately
* named _prim (not memristor_tio2_au) to avoid a real, recursive
* self-reference against the cell's own extracted top-level subckt,
* which is also named memristor_tio2_au.
*
* `mm` is ngspice's own real OSDI-backed memristor_tio2_au model,
* auto-loaded from memristor_tio2_au.osdi (compiled by openvaf from
* user_models/veriloga/memristor_tio2_au.va) once that file sits in
* the simulation's own working directory -- the same real convention
* docs/simulation/memristor_tio2_au/mem_tran.sp already uses.
.model mm memristor_tio2_au ron=100 roff=16k d=10n uv=1e-14 x0=0.3

.subckt memristor_tio2_au_prim BE TE
n1 BE TE mm
.ends
