* NGSPICE file created from memristor_tio2_au.ext - technology: openmemristorpdk

.subckt memristor_tio2_au BE TE
.ends
