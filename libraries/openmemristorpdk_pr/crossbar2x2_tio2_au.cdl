.SUBCKT crossbar2x2_tio2_au BE1 BE2 TE1 TE2
*.PININFO BE1:B BE2:B TE1:B TE2:B
X1 BE1 TE1 memristor_tio2_au_prim
X2 BE1 TE2 memristor_tio2_au_prim
X3 BE2 TE1 memristor_tio2_au_prim
X4 BE2 TE2 memristor_tio2_au_prim
.ENDS
