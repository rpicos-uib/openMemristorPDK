.SUBCKT memristor_tio2_au BE TE
*.PININFO BE:B TE:B
.ENDS
