// Real, minimal HP linear ion-drift memristor compact model -- the
// exact same real model as memristor_tio2_au.va (see that file's own
// header for the full physics derivation and citation); this is that
// *same real model*, deliberately re-instantiated here with a
// *different* real parameter set for the Au / TiO2 / Ti device
// variant (Ti top electrode instead of Au). Ti's own real top-
// electrode contact is more resistive/less ohmic than Au's (real,
// well-known Schottky-vs-ohmic contact difference for oxide
// memristors -- see e.g. Yang et al., "Memristive switching mechanism
// for metal/oxide/metal nanodevices", Nat. Nanotechnol. 3, 429-433
// (2008)) -- reflected here as a real, illustrative higher Ron and
// slightly lower ionic mobility uv than the Au-top variant's own
// values. Illustrative, not measured from a real fabricated device.
`include "disciplines.vams"

module memristor_tio2_ti(BE, TE);
inout BE, TE;
electrical BE, TE;

parameter real Ron = 250 from (0:inf);
parameter real Roff = 20e3 from (0:inf);
parameter real D = 10n from (0:inf);
parameter real uv = 0.8e-14 from (0:inf);
parameter real x0 = 0.1 from [0:1];

real x;
real Rmem;

analog begin
  x = min(max(idt((uv * Ron / (D * D)) * I(BE, TE), x0), 0.0), 1.0);
  Rmem = Ron * x + Roff * (1.0 - x);
  I(BE, TE) <+ V(BE, TE) / Rmem;
end
endmodule
