// A real, minimal *bipolar threshold-switching* memristor compact
// model -- deliberately a genuinely different real model from
// memristor_tio2_au.va/memristor_tio2_ti.va's linear ion-drift form,
// not just a renamed copy with different parameters (per direct
// request: "two different verilog models... [for] material1... [and]
// material2"). HfO2-based RRAM is real, widely reported to switch by
// *filamentary* conduction (a real, localized conductive filament of
// oxygen vacancies forming/rupturing through the oxide), not the
// linear-drift *boundary-motion* picture the classical HP TiO2 model
// uses -- a real, qualitatively different physical picture, so a
// qualitatively different real model structure: a state variable that
// only moves once the real terminal voltage crosses a real threshold
// (SET/RESET), and an exponential (tunneling-like) state-to-resistance
// mapping instead of a linear one. This is a real, simplified,
// illustrative form of the general real threshold-switching structure
// widely used for filamentary RRAM compact models -- see e.g.
// Kvatinsky et al., "TEAM: ThrEshold Adaptive Memristor Model", IEEE
// TCAS-I 60(1), 211-221 (2013), and Yakopcic et al., "A Memristor
// Device Model", IEEE EDL 32(10), 1436-1438 (2011), for the real,
// general lineage this borrows its threshold-switching + exponential-
// conduction structure from -- not a literal reimplementation of
// either (both are considerably more elaborate; this stays a bare-
// minimum, from-scratch teaching model, same real scope as its TiO2
// sibling). Al top electrode: a real, common RRAM top-electrode metal
// choice (its own native oxide is itself sometimes exploited as part
// of a real bilayer RRAM stack elsewhere in the literature; here it's
// simply the third, distinct real top-electrode metal this PDK's own
// task called for, bottom electrode still always Au).
//
// State: x lives on a hidden node, dx = x - x0, integrated with
// ddt() so that (1) the starting value x0 really is the starting
// value (dx starts at 0), and (2) x stops at 0 and 1 instead of
// piling up past them. (An earlier version clamped idt()'s output
// from outside: the integral kept growing past 1, so switching back
// was delayed, and x0 was ignored.)
`include "disciplines.vams"

module memristor_hfo2_al(BE, TE);
inout BE, TE;
electrical BE, TE;
electrical dx;   // hidden node: how far x has moved from x0

parameter real Ron = 500 from (0:inf);
parameter real Roff = 50e3 from (0:inf);
parameter real Von = 0.8;
parameter real Voff = -0.6 from (-inf:0);
parameter real tau = 5n from (0:inf);
parameter real x0 = 0.1 from [0:1];

real x, Rmem, dxdt;

analog begin
  x = min(max(x0 + V(dx), 0.0), 1.0);   // the memory, kept between 0 and 1
  dxdt = 0.0;                           // below the thresholds: no change
  if (V(BE, TE) > Von)
    dxdt = (V(BE, TE) - Von) / tau;     // SET: x grows
  else if (V(BE, TE) < Voff)
    dxdt = (V(BE, TE) - Voff) / tau;    // RESET: x shrinks
  if ((x >= 1.0 && dxdt > 0.0) || (x <= 0.0 && dxdt < 0.0))
    dxdt = 0.0;                         // at an end: stop there
  I(dx) <+ ddt(V(dx)) - dxdt;           // x moves at dxdt
  I(dx) <+ 1e-12 * V(dx);               // keeps dx defined at rest
  Rmem = Roff * exp(-x * ln(Roff / Ron));
  I(BE, TE) <+ V(BE, TE) / Rmem;
end
endmodule
